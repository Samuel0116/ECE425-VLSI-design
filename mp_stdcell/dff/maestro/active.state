ADE simulation setup
Test mp_stdcell_dff_1: mp_stdcell/dff/schematic, simulator spectre
  Models: /class/ece425/FreePDK45/ncsu_basekit/models/hspice/hspice_nom.include
  Temperature: 27
  Stimulus D: voltage bit val1=0 val0=1 delay=0 rise=2.5p fall=2.5p period=2.5n srcType=bit data=00110011
  Stimulus CLK: voltage bit val1=0 val0=1 delay=0 rise=2.5p fall=2.5p period=2.5n srcType=bit data=01010101
  Stimulus vdd!: voltage dc dc=1 srcType=dc
  Stimulus vss!: voltage dc dc=0 srcType=dc
  Analysis tran: stop=20n
  Signals: /D, /EN1, /Q
