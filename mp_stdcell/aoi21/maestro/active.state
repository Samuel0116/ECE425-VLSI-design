ADE simulation setup
Test mp_stdcell_aoi21_1: mp_stdcell/aoi21/schematic, simulator spectre
  Models: /class/ece425/FreePDK45/ncsu_basekit/models/hspice/hspice_nom.include
  Temperature: 27
  Stimulus A: voltage bit val1=1 val0=0 delay=0 rise=10p fall=10p period=2.5n srcType=bit data=00001111
  Stimulus B: voltage bit val1=1 val0=0 delay=0 rise=10p fall=10p period=2.5n srcType=bit data=00110011
  Stimulus C: voltage bit val1=1 val0=0 delay=0 rise=10p fall=10p period=2.5n srcType=bit data=01010101
  Stimulus vss!: voltage dc dc=0 srcType=dc
  Stimulus vdd!: voltage dc dc=1 srcType=dc
  Analysis tran: stop=20n
  Signals: /C, /B, /A, /Y
