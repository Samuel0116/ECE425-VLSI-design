ADE simulation setup
Run mode: Single Run, Sweeps and Corners
Tests:
  mp_stdcell_xor_1: mp_stdcell/xor2/schematic, simulator spectre
